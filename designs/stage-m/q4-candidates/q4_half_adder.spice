* q4_half_adder: UNQUALIFIED SKY130 01v8 transistor candidate, nominal 0/0.6/1.2/1.8V.
* Targets LDO +/-5% (1.89 V maximum). No DRC/LVS/PEX/SPICE corner evidence.
* MOS X-instance pin order: drain gate source bulk; w/l in micrometres.
* The native runner must separately authenticate the PDK and all devices.

* Requested 0.30, 0.90, 1.50 V are target trips, NOT MEASURED.
.subckt q4_thresh_det vin t1 t2 t3 vdd vss
Xn_lo trip_lo vin vss vss sky130_fd_pr__nfet_01v8_lvt w=8.00 l=0.35
Xp_lo trip_lo vin vdd vdd sky130_fd_pr__pfet_01v8_hvt w=0.60 l=0.35
Xn_buf_lo t1 trip_lo vss vss sky130_fd_pr__nfet_01v8 w=0.65 l=0.35
Xp_buf_lo t1 trip_lo vdd vdd sky130_fd_pr__pfet_01v8 w=1.30 l=0.35
Xn_mid trip_mid vin vss vss sky130_fd_pr__nfet_01v8 w=1.20 l=0.35
Xp_mid trip_mid vin vdd vdd sky130_fd_pr__pfet_01v8 w=2.40 l=0.35
Xn_buf_mid t2 trip_mid vss vss sky130_fd_pr__nfet_01v8 w=0.65 l=0.35
Xp_buf_mid t2 trip_mid vdd vdd sky130_fd_pr__pfet_01v8 w=1.30 l=0.35
Xn_hi trip_hi vin vss vss sky130_fd_pr__nfet_01v8 w=0.60 l=0.35
Xp_hi trip_hi vin vdd vdd sky130_fd_pr__pfet_01v8_hvt w=12.00 l=0.35
Xn_buf_hi t3 trip_hi vss vss sky130_fd_pr__nfet_01v8 w=0.65 l=0.35
Xp_buf_hi t3 trip_hi vdd vdd sky130_fd_pr__pfet_01v8 w=1.30 l=0.35
.ends q4_thresh_det

.subckt q4_mux4__bool_not i o vdd vss
Xn_not o i vss vss sky130_fd_pr__nfet_01v8 w=0.65 l=0.35
Xp_not o i vdd vdd sky130_fd_pr__pfet_01v8 w=1.30 l=0.35
.ends q4_mux4__bool_not
.subckt q4_mux4__bool_nand2 a b o vdd vss
Xn_na o a nmid vss sky130_fd_pr__nfet_01v8 w=1.20 l=0.35
Xn_nb nmid b vss vss sky130_fd_pr__nfet_01v8 w=1.20 l=0.35
Xp_na o a vdd vdd sky130_fd_pr__pfet_01v8 w=1.30 l=0.35
Xp_nb o b vdd vdd sky130_fd_pr__pfet_01v8 w=1.30 l=0.35
.ends q4_mux4__bool_nand2
* Thermometer decode with 4 complementary low-Vt NMOS + standard PMOS transmission gates.
.subckt q4_mux4 sel d0 d1 d2 d3 out vdd vss
Xdet sel t1 t2 t3 vdd vss q4_thresh_det
Xs0 t1 s0 vdd vss q4_mux4__bool_not
Xt2bar t2 nt2 vdd vss q4_mux4__bool_not
Xt3bar t3 nt3 vdd vss q4_mux4__bool_not
Xns1 t1 nt2 ns1 vdd vss q4_mux4__bool_nand2
Xs1 ns1 s1 vdd vss q4_mux4__bool_not
Xns2 t2 nt3 ns2 vdd vss q4_mux4__bool_nand2
Xs2 ns2 s2 vdd vss q4_mux4__bool_not
* S0=!t1, S1=t1&&!t2, S2=t2&&!t3, S3=t3.
Xn_tg0 out d0 s0 vss sky130_fd_pr__nfet_01v8_lvt w=1.20 l=0.35
Xp_tg0 out d0 t1 vdd sky130_fd_pr__pfet_01v8 w=2.40 l=0.35
Xn_tg1 out d1 s1 vss sky130_fd_pr__nfet_01v8_lvt w=1.20 l=0.35
Xp_tg1 out d1 ns1 vdd sky130_fd_pr__pfet_01v8 w=2.40 l=0.35
Xn_tg2 out d2 s2 vss sky130_fd_pr__nfet_01v8_lvt w=1.20 l=0.35
Xp_tg2 out d2 ns2 vdd sky130_fd_pr__pfet_01v8 w=2.40 l=0.35
Xn_tg3 out d3 t3 vss sky130_fd_pr__nfet_01v8_lvt w=1.20 l=0.35
Xp_tg3 out d3 nt3 vdd sky130_fd_pr__pfet_01v8 w=2.40 l=0.35
.ends q4_mux4

.subckt q4_half_adder a b sum carry v0 v1 v2 v3
Xsum_b0 b v0 v1 v2 v3 s0 v3 v0 q4_mux4
Xcarry_b0 b v0 v0 v0 v0 c0 v3 v0 q4_mux4
Xsum_b1 b v1 v2 v3 v0 s1 v3 v0 q4_mux4
Xcarry_b1 b v0 v0 v0 v1 c1 v3 v0 q4_mux4
Xsum_b2 b v2 v3 v0 v1 s2 v3 v0 q4_mux4
Xcarry_b2 b v0 v0 v1 v1 c2 v3 v0 q4_mux4
Xsum_b3 b v3 v0 v1 v2 s3 v3 v0 q4_mux4
Xcarry_b3 b v0 v1 v1 v1 c3 v3 v0 q4_mux4
Xsum_a a s0 s1 s2 s3 sum v3 v0 q4_mux4
Xcarry_a a c0 c1 c2 c3 carry v3 v0 q4_mux4
.ends q4_half_adder
